*TB_ADI_SA_SKY130A
*----------------------------------------------------------------
* Include
*----------------------------------------------------------------
#ifdef Lay
.include ../../../work/lpe/ADI_SA_lpe.spi
#else
.include ../../../work/xsch/ADI_SA.spice
#endif
*-----------------------------------------------------------------
* OPTIONS
*-----------------------------------------------------------------
.option TNOM=27 GMIN=1e-15 reltol=1e-3
*-----------------------------------------------------------------
* PARAMETERS
*-----------------------------------------------------------------
.param TRF  = 100p
.param AVDD = {vdda}
.param VCM  = 0.9
.param VDIFF = 10m
*-----------------------------------------------------------------
* FORCE
*-----------------------------------------------------------------
VSS   VSS       0    dc 0
VDD   VDD   VSS  pwl 0 0 10n {AVDD}
VCLK  CLK       VSS  pulse(0 {AVDD} 0 {TRF} {TRF} 10n 20n)
VINP  INP       VSS  dc {VCM + VDIFF/2}
VINN  INN       VSS  dc {VCM - VDIFF/2}
*-----------------------------------------------------------------
* DUT
*-----------------------------------------------------------------
.include ../xdut.spi
*----------------------------------------------------------------
* PROBE
*----------------------------------------------------------------
.save all
*----------------------------------------------------------------
* NGSPICE control
*----------------------------------------------------------------
.control
set num_threads=8
set color0=white
set color1=black
unset askquit
optran 0 0 0 100p 2n 0
tran 0.1n 200n
write
quit
.endc
.end
